//Verilog-AMS HDL for "ADC", "comparator" "verilogams"
`include "constants.vams"
`include "disciplines.vams"

module comparator (in,ref,out);
    input in, ref;
    output reg out;
    electrical in, ref;

    initial begin
        out = 1'b0;
    end

    always@(cross(V(in) - V(ref),+1)) begin
        out = 1'b1;
    end

    always@(cross(V(in) - V(ref),-1)) begin
        out = 1'b0;
    end
endmodule
